* NGSPICE file created from pulldown_mosfet_cap_0410.ext - technology: sky130A

.subckt sky130_fd_pr__nfet_01v8_HHPQSU a_25_n100# a_n33_n188# a_n185_n274# a_n83_n100#
X0 a_25_n100# a_n33_n188# a_n83_n100# a_n185_n274# sky130_fd_pr__nfet_01v8 ad=0.29 pd=2.58 as=0.29 ps=2.58 w=1 l=0.25
.ends

.subckt sky130_fd_pr__nfet_01v8_2B38KW a_n260_n274# a_100_n100# a_n158_n100# a_n100_n188#
X0 a_100_n100# a_n100_n188# a_n158_n100# a_n260_n274# sky130_fd_pr__nfet_01v8 ad=0.29 pd=2.58 as=0.29 ps=2.58 w=1 l=1
.ends

.subckt sky130_fd_pr__cap_mim_m3_1_A5W7HU m3_n386_n240# c1_n346_n200#
X0 c1_n346_n200# m3_n386_n240# sky130_fd_pr__cap_mim_m3_1 l=2 w=2
.ends

.subckt transistor_evaluate_cap_0410 A1 BIAS VDD VSS
XXM4 VDD A1 VSS VSS sky130_fd_pr__nfet_01v8_HHPQSU
XXM5 VSS VSS A1 BIAS sky130_fd_pr__nfet_01v8_2B38KW
XXC1 VSS BIAS sky130_fd_pr__cap_mim_m3_1_A5W7HU
XXC2 VSS A1 sky130_fd_pr__cap_mim_m3_1_A5W7HU
.ends

.subckt pulldown_mosfet_cap_0410 A2 A3 VDD A1 VSS BIAS A4 A5 A6 A7 A8
Xx1 A1 BIAS VDD VSS transistor_evaluate_cap_0410
Xx3 A3 BIAS VDD VSS transistor_evaluate_cap_0410
Xx2 A2 BIAS VDD VSS transistor_evaluate_cap_0410
Xx4 A4 BIAS VDD VSS transistor_evaluate_cap_0410
Xx5 A5 BIAS VDD VSS transistor_evaluate_cap_0410
Xx6 A6 BIAS VDD VSS transistor_evaluate_cap_0410
Xx7 A7 BIAS VDD VSS transistor_evaluate_cap_0410
Xx8 A8 BIAS VDD VSS transistor_evaluate_cap_0410
.ends
