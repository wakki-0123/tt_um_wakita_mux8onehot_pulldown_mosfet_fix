* NGSPICE file created from mux8onehot_cap_0410_true_flatten.ext - technology: sky130A

.subckt mux8onehot_cap_0410_true_flatten SEL0 SEL1 SEL2 VDD V_gate BIAS V_drain
X0 x1.x5.A x1.x3.GN3 x2.A3 VSS sky130_fd_pr__nfet_01v8_lvt ad=2.32 pd=16.58 as=2.32 ps=16.58 w=8 l=0.35
X1 VDD VSS VDD VDD sky130_fd_pr__pfet_01v8_hvt ad=0.2262 pd=2.26 as=7.5482 ps=71.72 w=0.87 l=1.05
X2 x2.A8 VSS sky130_fd_pr__cap_mim_m3_1 l=2 w=2
X3 x2.A2 x1.x3.GP2 x1.x5.A VDD sky130_fd_pr__pfet_01v8_lvt ad=2.9 pd=20.58 as=2.9 ps=20.58 w=10 l=0.35
X4 VSS x1.x3.GN1 x1.x3.GP1 VSS sky130_fd_pr__nfet_01v8 ad=0.169 pd=1.82 as=0.1755 ps=1.84 w=0.65 l=0.15
X5 a_12432_5600# a_12432_5776# a_12458_5728# VSS sky130_fd_pr__nfet_01v8 ad=0.1092 pd=1.36 as=0.0504 ps=0.66 w=0.42 l=0.15
X6 VSS SEL0 a_12432_5776# VSS sky130_fd_pr__nfet_01v8 ad=0.1092 pd=1.36 as=0.1092 ps=1.36 w=0.42 l=0.15
X7 VSS VDD VSS VSS sky130_fd_pr__nfet_01v8 ad=0.143 pd=1.62 as=9.2208 ps=90.56 w=0.55 l=1.05
X8 BIAS VSS sky130_fd_pr__cap_mim_m3_1 l=2 w=2
X9 BIAS VSS sky130_fd_pr__cap_mim_m3_1 l=2 w=2
X10 x1.x4.A x1.x3.GN2 x2.A6 VSS sky130_fd_pr__nfet_01v8_lvt ad=2.32 pd=16.58 as=2.32 ps=16.58 w=8 l=0.35
X11 x1.x1.nSEL1 SEL1 VDD VDD sky130_fd_pr__pfet_01v8_hvt ad=0.27 pd=2.54 as=0.26 ps=2.52 w=1 l=0.15
X12 VDD a_12432_5600# x1.x3.GN3 VDD sky130_fd_pr__pfet_01v8_hvt ad=0.2279 pd=1.74 as=0.26 ps=2.52 w=1 l=0.15
X13 VSS BIAS x2.A7 VSS sky130_fd_pr__nfet_01v8 ad=0.29 pd=2.58 as=0.29 ps=2.58 w=1 l=1
X14 x2.A5 x1.x3.GP1 x1.x4.A VDD sky130_fd_pr__pfet_01v8_lvt ad=2.9 pd=20.58 as=2.9 ps=20.58 w=10 l=0.35
X15 BIAS VSS sky130_fd_pr__cap_mim_m3_1 l=2 w=2
X16 BIAS VSS sky130_fd_pr__cap_mim_m3_1 l=2 w=2
X17 x2.A2 VSS sky130_fd_pr__cap_mim_m3_1 l=2 w=2
X18 VSS BIAS x2.A2 VSS sky130_fd_pr__nfet_01v8 ad=0.29 pd=2.58 as=0.29 ps=2.58 w=1 l=1
X19 x1.x3.GP4 x1.x3.GN4 VDD VDD sky130_fd_pr__pfet_01v8_hvt ad=0.27 pd=2.54 as=0.26 ps=2.52 w=1 l=0.15
X20 V_drain x2.A6 VSS VSS sky130_fd_pr__nfet_01v8 ad=0.29 pd=2.58 as=0.29 ps=2.58 w=1 l=0.25
X21 V_gate x1.x5.GN x1.x5.A VSS sky130_fd_pr__nfet_01v8_lvt ad=2.32 pd=16.58 as=2.32 ps=16.58 w=8 l=0.35
X22 V_drain x2.A1 VSS VSS sky130_fd_pr__nfet_01v8 ad=0.29 pd=2.58 as=0.29 ps=2.58 w=1 l=0.25
X23 x2.A6 VSS sky130_fd_pr__cap_mim_m3_1 l=2 w=2
X24 x2.A7 VSS sky130_fd_pr__cap_mim_m3_1 l=2 w=2
X25 a_12432_6288# SEL1 a_12486_6426# VSS sky130_fd_pr__nfet_01v8 ad=0.1176 pd=1.4 as=0.0567 ps=0.69 w=0.42 l=0.15
X26 x1.x4.A x1.x3.GN4 x2.A8 VSS sky130_fd_pr__nfet_01v8_lvt ad=2.32 pd=16.58 as=2.32 ps=16.58 w=8 l=0.35
X27 V_drain x2.A3 VSS VSS sky130_fd_pr__nfet_01v8 ad=0.29 pd=2.58 as=0.29 ps=2.58 w=1 l=0.25
X28 x2.A3 x1.x3.GP3 x1.x5.A VDD sky130_fd_pr__pfet_01v8_lvt ad=2.9 pd=20.58 as=2.9 ps=20.58 w=10 l=0.35
X29 VDD x1.x3.GN1 x1.x3.GP1 VDD sky130_fd_pr__pfet_01v8_hvt ad=0.26 pd=2.52 as=0.27 ps=2.54 w=1 l=0.15
X30 a_12486_6426# SEL0 VSS VSS sky130_fd_pr__nfet_01v8 ad=0.0567 pd=0.69 as=0.1118 ps=1.04 w=0.42 l=0.15
X31 VSS VDD VSS VSS sky130_fd_pr__nfet_01v8 ad=0.143 pd=1.62 as=0 ps=0 w=0.55 l=1.05
X32 x1.x5.A x1.x3.GN2 x2.A2 VSS sky130_fd_pr__nfet_01v8_lvt ad=2.32 pd=16.58 as=2.32 ps=16.58 w=8 l=0.35
X33 a_12432_4632# x1.x1.nSEL0 a_12486_4770# VSS sky130_fd_pr__nfet_01v8 ad=0.1176 pd=1.4 as=0.0567 ps=0.69 w=0.42 l=0.15
X34 x1.x1.nSEL1 SEL1 VSS VSS sky130_fd_pr__nfet_01v8 ad=0.1755 pd=1.84 as=0.169 ps=1.82 w=0.65 l=0.15
X35 VDD a_12432_5224# a_12432_5048# VDD sky130_fd_pr__pfet_01v8_hvt ad=0.0714 pd=0.76 as=0.0609 ps=0.71 w=0.42 l=0.15
X36 VSS BIAS x2.A6 VSS sky130_fd_pr__nfet_01v8 ad=0.29 pd=2.58 as=0.29 ps=2.58 w=1 l=1
X37 VSS a_12432_4632# x1.x3.GN1 VSS sky130_fd_pr__nfet_01v8 ad=0.1118 pd=1.04 as=0.182 ps=1.86 w=0.65 l=0.15
X38 VSS BIAS x2.A1 VSS sky130_fd_pr__nfet_01v8 ad=0.29 pd=2.58 as=0.29 ps=2.58 w=1 l=1
X39 VSS BIAS x2.A5 VSS sky130_fd_pr__nfet_01v8 ad=0.29 pd=2.58 as=0.29 ps=2.58 w=1 l=1
X40 a_12432_5224# SEL1 VDD VDD sky130_fd_pr__pfet_01v8_hvt ad=0.1092 pd=1.36 as=0.0714 ps=0.76 w=0.42 l=0.15
X41 x1.x4.A x1.x3.GN2 x2.A6 VSS sky130_fd_pr__nfet_01v8_lvt ad=2.32 pd=16.58 as=2.32 ps=16.58 w=8 l=0.35
X42 VSS x1.x3.GN3 x1.x3.GP3 VSS sky130_fd_pr__nfet_01v8 ad=0.169 pd=1.82 as=0.1755 ps=1.84 w=0.65 l=0.15
X43 x2.A2 x1.x3.GP2 x1.x5.A VDD sky130_fd_pr__pfet_01v8_lvt ad=2.9 pd=20.58 as=2.9 ps=20.58 w=10 l=0.35
X44 VDD SEL2 x1.x5.GN VDD sky130_fd_pr__pfet_01v8_hvt ad=0.26 pd=2.52 as=0.27 ps=2.54 w=1 l=0.15
X45 x1.x5.A x1.x3.GN2 x2.A2 VSS sky130_fd_pr__nfet_01v8_lvt ad=2.32 pd=16.58 as=2.32 ps=16.58 w=8 l=0.35
X46 VDD SEL1 a_12432_6288# VDD sky130_fd_pr__pfet_01v8_hvt ad=0.1176 pd=1.4 as=0.0567 ps=0.69 w=0.42 l=0.15
X47 VSS x1.x3.GN2 x1.x3.GP2 VSS sky130_fd_pr__nfet_01v8 ad=0.169 pd=1.82 as=0.1755 ps=1.84 w=0.65 l=0.15
X48 x1.x3.GP1 x1.x3.GN1 VSS VSS sky130_fd_pr__nfet_01v8 ad=0.1755 pd=1.84 as=0.169 ps=1.82 w=0.65 l=0.15
X49 BIAS VSS sky130_fd_pr__cap_mim_m3_1 l=2 w=2
X50 x2.A3 VSS sky130_fd_pr__cap_mim_m3_1 l=2 w=2
X51 x2.A1 x1.x3.GP1 x1.x5.A VDD sky130_fd_pr__pfet_01v8_lvt ad=2.9 pd=20.58 as=2.9 ps=20.58 w=10 l=0.35
X52 a_12432_6288# SEL0 VDD VDD sky130_fd_pr__pfet_01v8_hvt ad=0.0567 pd=0.69 as=0.16655 ps=1.39 w=0.42 l=0.15
X53 VDD x1.x1.nSEL0 a_12432_4632# VDD sky130_fd_pr__pfet_01v8_hvt ad=0.1176 pd=1.4 as=0.0567 ps=0.69 w=0.42 l=0.15
X54 x1.x3.GP2 x1.x3.GN2 VSS VSS sky130_fd_pr__nfet_01v8 ad=0.1755 pd=1.84 as=0.169 ps=1.82 w=0.65 l=0.15
X55 x2.A4 VSS sky130_fd_pr__cap_mim_m3_1 l=2 w=2
X56 x1.x4.A x1.x3.GN4 x2.A8 VSS sky130_fd_pr__nfet_01v8_lvt ad=2.32 pd=16.58 as=2.32 ps=16.58 w=8 l=0.35
X57 V_drain x2.A2 VSS VSS sky130_fd_pr__nfet_01v8 ad=0.29 pd=2.58 as=0.29 ps=2.58 w=1 l=0.25
X58 a_12458_5728# SEL1 VSS VSS sky130_fd_pr__nfet_01v8 ad=0.0504 pd=0.66 as=0.1013 ps=0.99 w=0.42 l=0.15
X59 x1.x5.GN SEL2 VDD VDD sky130_fd_pr__pfet_01v8_hvt ad=0.27 pd=2.54 as=0.26 ps=2.52 w=1 l=0.15
X60 x1.x4.A x1.x5.GN V_gate VDD sky130_fd_pr__pfet_01v8_lvt ad=2.9 pd=20.58 as=2.9 ps=20.58 w=10 l=0.35
X61 VDD a_12432_5048# x1.x3.GN2 VDD sky130_fd_pr__pfet_01v8_hvt ad=0.2279 pd=1.74 as=0.26 ps=2.52 w=1 l=0.15
X62 a_12432_5048# a_12432_5224# a_12458_5176# VSS sky130_fd_pr__nfet_01v8 ad=0.1092 pd=1.36 as=0.0504 ps=0.66 w=0.42 l=0.15
X63 x2.A4 x1.x3.GP4 x1.x5.A VDD sky130_fd_pr__pfet_01v8_lvt ad=2.9 pd=20.58 as=2.9 ps=20.58 w=10 l=0.35
X64 VSS SEL1 a_12432_5224# VSS sky130_fd_pr__nfet_01v8 ad=0.1092 pd=1.36 as=0.1092 ps=1.36 w=0.42 l=0.15
X65 VSS a_12432_5600# x1.x3.GN3 VSS sky130_fd_pr__nfet_01v8 ad=0.1013 pd=0.99 as=0.169 ps=1.82 w=0.65 l=0.15
X66 VSS SEL2 x1.x5.GN VSS sky130_fd_pr__nfet_01v8 ad=0.169 pd=1.82 as=0.1755 ps=1.84 w=0.65 l=0.15
X67 x2.A6 x1.x3.GP2 x1.x4.A VDD sky130_fd_pr__pfet_01v8_lvt ad=2.9 pd=20.58 as=2.9 ps=20.58 w=10 l=0.35
X68 x2.A4 x1.x3.GP4 x1.x5.A VDD sky130_fd_pr__pfet_01v8_lvt ad=2.9 pd=20.58 as=2.9 ps=20.58 w=10 l=0.35
X69 VDD x1.x3.GN3 x1.x3.GP3 VDD sky130_fd_pr__pfet_01v8_hvt ad=0.26 pd=2.52 as=0.27 ps=2.54 w=1 l=0.15
X70 V_drain x2.A5 VSS VSS sky130_fd_pr__nfet_01v8 ad=0.29 pd=2.58 as=0.29 ps=2.58 w=1 l=0.25
X71 x1.x4.A x1.x3.GN1 x2.A5 VSS sky130_fd_pr__nfet_01v8_lvt ad=2.32 pd=16.58 as=2.32 ps=16.58 w=8 l=0.35
X72 a_12432_5600# SEL1 VDD VDD sky130_fd_pr__pfet_01v8_hvt ad=0.0609 pd=0.71 as=0.2279 ps=1.74 w=0.42 l=0.15
X73 x2.A1 VSS sky130_fd_pr__cap_mim_m3_1 l=2 w=2
X74 V_gate x1.x5.GN x1.x5.A VSS sky130_fd_pr__nfet_01v8_lvt ad=2.32 pd=16.58 as=2.32 ps=16.58 w=8 l=0.35
X75 VDD x1.x3.GN2 x1.x3.GP2 VDD sky130_fd_pr__pfet_01v8_hvt ad=0.26 pd=2.52 as=0.27 ps=2.54 w=1 l=0.15
X76 VDD a_12432_6288# x1.x3.GN4 VDD sky130_fd_pr__pfet_01v8_hvt ad=0.16655 pd=1.39 as=0.475 ps=2.95 w=1 l=0.15
X77 x1.x3.GP1 x1.x3.GN1 VDD VDD sky130_fd_pr__pfet_01v8_hvt ad=0.27 pd=2.54 as=0.26 ps=2.52 w=1 l=0.15
X78 VDD VSS VDD VDD sky130_fd_pr__pfet_01v8_hvt ad=0.2262 pd=2.26 as=0 ps=0 w=0.87 l=1.05
X79 BIAS VSS sky130_fd_pr__cap_mim_m3_1 l=2 w=2
X80 x1.x4.A x1.x3.GN3 x2.A7 VSS sky130_fd_pr__nfet_01v8_lvt ad=2.32 pd=16.58 as=2.32 ps=16.58 w=8 l=0.35
X81 x2.A3 x1.x3.GP3 x1.x5.A VDD sky130_fd_pr__pfet_01v8_lvt ad=2.9 pd=20.58 as=2.9 ps=20.58 w=10 l=0.35
X82 x1.x5.GN SEL2 VSS VSS sky130_fd_pr__nfet_01v8 ad=0.1755 pd=1.84 as=0.169 ps=1.82 w=0.65 l=0.15
X83 V_gate SEL2 x1.x4.A VSS sky130_fd_pr__nfet_01v8_lvt ad=2.32 pd=16.58 as=2.32 ps=16.58 w=8 l=0.35
X84 a_12486_4770# x1.x1.nSEL1 VSS VSS sky130_fd_pr__nfet_01v8 ad=0.0567 pd=0.69 as=0.1118 ps=1.04 w=0.42 l=0.15
X85 VSS VDD VSS VSS sky130_fd_pr__nfet_01v8 ad=0.143 pd=1.62 as=0 ps=0 w=0.55 l=1.05
X86 x1.x5.A SEL2 V_gate VDD sky130_fd_pr__pfet_01v8_lvt ad=2.9 pd=20.58 as=2.9 ps=20.58 w=10 l=0.35
X87 x1.x3.GP2 x1.x3.GN2 VDD VDD sky130_fd_pr__pfet_01v8_hvt ad=0.27 pd=2.54 as=0.26 ps=2.52 w=1 l=0.15
X88 VSS BIAS x2.A8 VSS sky130_fd_pr__nfet_01v8 ad=0.29 pd=2.58 as=0.29 ps=2.58 w=1 l=1
X89 VSS BIAS x2.A4 VSS sky130_fd_pr__nfet_01v8 ad=0.29 pd=2.58 as=0.29 ps=2.58 w=1 l=1
X90 x2.A8 x1.x3.GP4 x1.x4.A VDD sky130_fd_pr__pfet_01v8_lvt ad=2.9 pd=20.58 as=2.9 ps=20.58 w=10 l=0.35
X91 x2.A8 x1.x3.GP4 x1.x4.A VDD sky130_fd_pr__pfet_01v8_lvt ad=2.9 pd=20.58 as=2.9 ps=20.58 w=10 l=0.35
X92 x1.x4.A x1.x3.GN1 x2.A5 VSS sky130_fd_pr__nfet_01v8_lvt ad=2.32 pd=16.58 as=2.32 ps=16.58 w=8 l=0.35
X93 x1.x3.GP3 x1.x3.GN3 VSS VSS sky130_fd_pr__nfet_01v8 ad=0.1755 pd=1.84 as=0.169 ps=1.82 w=0.65 l=0.15
X94 x2.A6 x1.x3.GP2 x1.x4.A VDD sky130_fd_pr__pfet_01v8_lvt ad=2.9 pd=20.58 as=2.9 ps=20.58 w=10 l=0.35
X95 V_drain x2.A7 VSS VSS sky130_fd_pr__nfet_01v8 ad=0.29 pd=2.58 as=0.29 ps=2.58 w=1 l=0.25
X96 BIAS VSS sky130_fd_pr__cap_mim_m3_1 l=2 w=2
X97 x2.A5 x1.x3.GP1 x1.x4.A VDD sky130_fd_pr__pfet_01v8_lvt ad=2.9 pd=20.58 as=2.9 ps=20.58 w=10 l=0.35
X98 VSS x1.x3.GN4 x1.x3.GP4 VSS sky130_fd_pr__nfet_01v8 ad=0.169 pd=1.82 as=0.1755 ps=1.84 w=0.65 l=0.15
X99 VDD VSS VDD VDD sky130_fd_pr__pfet_01v8_hvt ad=0.2262 pd=2.26 as=0 ps=0 w=0.87 l=1.05
X100 x2.A5 VSS sky130_fd_pr__cap_mim_m3_1 l=2 w=2
X101 x2.A7 x1.x3.GP3 x1.x4.A VDD sky130_fd_pr__pfet_01v8_lvt ad=2.9 pd=20.58 as=2.9 ps=20.58 w=10 l=0.35
X102 x1.x1.nSEL0 SEL0 VDD VDD sky130_fd_pr__pfet_01v8_hvt ad=0.27 pd=2.54 as=0.26 ps=2.52 w=1 l=0.15
X103 x1.x5.A x1.x3.GN4 x2.A4 VSS sky130_fd_pr__nfet_01v8_lvt ad=2.32 pd=16.58 as=2.32 ps=16.58 w=8 l=0.35
X104 VDD SEL0 x1.x1.nSEL0 VDD sky130_fd_pr__pfet_01v8_hvt ad=0.26 pd=2.52 as=0.27 ps=2.54 w=1 l=0.15
X105 a_12432_4632# x1.x1.nSEL1 VDD VDD sky130_fd_pr__pfet_01v8_hvt ad=0.0567 pd=0.69 as=0.16655 ps=1.39 w=0.42 l=0.15
X106 V_drain x2.A4 VSS VSS sky130_fd_pr__nfet_01v8 ad=0.29 pd=2.58 as=0.29 ps=2.58 w=1 l=0.25
X107 VDD SEL1 x1.x1.nSEL1 VDD sky130_fd_pr__pfet_01v8_hvt ad=0.26 pd=2.52 as=0.27 ps=2.54 w=1 l=0.15
X108 x1.x5.A SEL2 V_gate VDD sky130_fd_pr__pfet_01v8_lvt ad=2.9 pd=20.58 as=2.9 ps=20.58 w=10 l=0.35
X109 x1.x4.A x1.x3.GN3 x2.A7 VSS sky130_fd_pr__nfet_01v8_lvt ad=2.32 pd=16.58 as=2.32 ps=16.58 w=8 l=0.35
X110 x1.x4.A x1.x5.GN V_gate VDD sky130_fd_pr__pfet_01v8_lvt ad=2.9 pd=20.58 as=2.9 ps=20.58 w=10 l=0.35
X111 VSS VDD VSS VSS sky130_fd_pr__nfet_01v8 ad=0.143 pd=1.62 as=0 ps=0 w=0.55 l=1.05
X112 x1.x5.A x1.x3.GN1 x2.A1 VSS sky130_fd_pr__nfet_01v8_lvt ad=2.32 pd=16.58 as=2.32 ps=16.58 w=8 l=0.35
X113 VSS a_12432_5048# x1.x3.GN2 VSS sky130_fd_pr__nfet_01v8 ad=0.1013 pd=0.99 as=0.169 ps=1.82 w=0.65 l=0.15
X114 x1.x5.A x1.x3.GN3 x2.A3 VSS sky130_fd_pr__nfet_01v8_lvt ad=2.32 pd=16.58 as=2.32 ps=16.58 w=8 l=0.35
X115 a_12458_5176# SEL0 VSS VSS sky130_fd_pr__nfet_01v8 ad=0.0504 pd=0.66 as=0.1013 ps=0.99 w=0.42 l=0.15
X116 x2.A7 x1.x3.GP3 x1.x4.A VDD sky130_fd_pr__pfet_01v8_lvt ad=2.9 pd=20.58 as=2.9 ps=20.58 w=10 l=0.35
X117 x1.x3.GP3 x1.x3.GN3 VDD VDD sky130_fd_pr__pfet_01v8_hvt ad=0.27 pd=2.54 as=0.26 ps=2.52 w=1 l=0.15
X118 x2.A1 x1.x3.GP1 x1.x5.A VDD sky130_fd_pr__pfet_01v8_lvt ad=2.9 pd=20.58 as=2.9 ps=20.58 w=10 l=0.35
X119 VDD VSS VDD VDD sky130_fd_pr__pfet_01v8_hvt ad=0.2262 pd=2.26 as=0 ps=0 w=0.87 l=1.05
X120 VDD a_12432_5776# a_12432_5600# VDD sky130_fd_pr__pfet_01v8_hvt ad=0.0714 pd=0.76 as=0.0609 ps=0.71 w=0.42 l=0.15
X121 x1.x1.nSEL0 SEL0 VSS VSS sky130_fd_pr__nfet_01v8 ad=0.1755 pd=1.84 as=0.169 ps=1.82 w=0.65 l=0.15
X122 a_12432_5776# SEL0 VDD VDD sky130_fd_pr__pfet_01v8_hvt ad=0.1092 pd=1.36 as=0.0714 ps=0.76 w=0.42 l=0.15
X123 VDD x1.x3.GN4 x1.x3.GP4 VDD sky130_fd_pr__pfet_01v8_hvt ad=0.26 pd=2.52 as=0.27 ps=2.54 w=1 l=0.15
X124 VSS SEL0 x1.x1.nSEL0 VSS sky130_fd_pr__nfet_01v8 ad=0.169 pd=1.82 as=0.1755 ps=1.84 w=0.65 l=0.15
X125 VDD a_12432_4632# x1.x3.GN1 VDD sky130_fd_pr__pfet_01v8_hvt ad=0.16655 pd=1.39 as=0.475 ps=2.95 w=1 l=0.15
X126 V_drain x2.A8 VSS VSS sky130_fd_pr__nfet_01v8 ad=0.29 pd=2.58 as=0.29 ps=2.58 w=1 l=0.25
X127 VSS SEL1 x1.x1.nSEL1 VSS sky130_fd_pr__nfet_01v8 ad=0.169 pd=1.82 as=0.1755 ps=1.84 w=0.65 l=0.15
X128 VSS a_12432_6288# x1.x3.GN4 VSS sky130_fd_pr__nfet_01v8 ad=0.1118 pd=1.04 as=0.182 ps=1.86 w=0.65 l=0.15
X129 BIAS VSS sky130_fd_pr__cap_mim_m3_1 l=2 w=2
X130 x1.x5.A x1.x3.GN4 x2.A4 VSS sky130_fd_pr__nfet_01v8_lvt ad=2.32 pd=16.58 as=2.32 ps=16.58 w=8 l=0.35
X131 a_12432_5048# SEL0 VDD VDD sky130_fd_pr__pfet_01v8_hvt ad=0.0609 pd=0.71 as=0.2279 ps=1.74 w=0.42 l=0.15
X132 V_gate SEL2 x1.x4.A VSS sky130_fd_pr__nfet_01v8_lvt ad=2.32 pd=16.58 as=2.32 ps=16.58 w=8 l=0.35
X133 x1.x3.GP4 x1.x3.GN4 VSS VSS sky130_fd_pr__nfet_01v8 ad=0.1755 pd=1.84 as=0.169 ps=1.82 w=0.65 l=0.15
X134 VSS BIAS x2.A3 VSS sky130_fd_pr__nfet_01v8 ad=0.29 pd=2.58 as=0.29 ps=2.58 w=1 l=1
X135 x1.x5.A x1.x3.GN1 x2.A1 VSS sky130_fd_pr__nfet_01v8_lvt ad=2.32 pd=16.58 as=2.32 ps=16.58 w=8 l=0.35
.ends
