* NGSPICE file created from transistor_verification.ext - technology: sky130A

.subckt sky130_fd_pr__nfet_01v8_HHPQSU a_25_n100# a_n33_n188# a_n185_n274# a_n83_n100#
X0 a_25_n100# a_n33_n188# a_n83_n100# a_n185_n274# sky130_fd_pr__nfet_01v8 ad=0.29 pd=2.58 as=0.29 ps=2.58 w=1 l=0.25
.ends

.subckt transistor_verification BIAS VDD A1 VSS
XXM4 VSS A1 VSS VDD sky130_fd_pr__nfet_01v8_HHPQSU
XXM5 A1 BIAS VSS VSS sky130_fd_pr__nfet_01v8_HHPQSU
.ends
