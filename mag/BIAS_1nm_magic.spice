* NGSPICE file created from BIAS_1nm.ext - technology: sky130A

.subckt sky130_fd_pr__nfet_01v8_2B38KW a_n260_n274# a_100_n100# a_n158_n100# a_n100_n188#
X0 a_100_n100# a_n100_n188# a_n158_n100# a_n260_n274# sky130_fd_pr__nfet_01v8 ad=0.29 pd=2.58 as=0.29 ps=2.58 w=1 l=1
.ends

.subckt sky130_fd_pr__pfet_01v8_WCDYZ6 w_n296_n319# a_n100_n197# a_100_n100# a_n158_n100#
X0 a_100_n100# a_n100_n197# a_n158_n100# w_n296_n319# sky130_fd_pr__pfet_01v8 ad=0.29 pd=2.58 as=0.29 ps=2.58 w=1 l=1
.ends

.subckt BIAS_1nm VDD VSS BIAS
XXM3 VSS BIAS VSS BIAS sky130_fd_pr__nfet_01v8_2B38KW
XXM11 VDD BIAS BIAS VDD sky130_fd_pr__pfet_01v8_WCDYZ6
.ends
